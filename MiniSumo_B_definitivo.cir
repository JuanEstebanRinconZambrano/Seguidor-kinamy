* =====================================================================
*  MiniSumo_B_definitivo.cir  --  CIRCUITO B (VERSION DEFINITIVA)
*  Version 1.0  -  2026-10-21
*  Proyecto: Mini Sumo (ESP32 + 2xN20 + driver + LiPo 2S + buck 5 V)
*
*  Incluye respecto al circuito A:
*   - DOS motores N20 con modelo electromecanico (fcem, inercia, torque)
*   - DOS puentes H (subcircuito HBR) con driver seleccionable:
*         driver=0 -> L293D      driver=1 -> TB6612FNG
*   - Bateria con resistencia interna, fusible + MOSFET anti-polaridad
*   - Buck 5 V como fuente de potencia equivalente (eficiencia eta)
*   - Cargas reales en el riel de 5 V (ESP32, HC-SR04, Sharp, driver, LEDs)
*   - 4 sensores IR de piso, divisor ECHO, divisor Sharp, pull-downs en EN
*   - Un "empuje" (torque de carga) a partir de tpush para ver el stall
*
*  Limitaciones (v1.0): el buck NO modela rizado de conmutacion; el
*  modelo de motor es de parametros concentrados (ajustar con medidas).
* =====================================================================

* ---------------- PARAMETROS EDITABLES -------------------------------
.param Vbat=7.4                 ; 6.0 / 7.4 / 8.4 V
.param driver=0                 ; 0 = L293D , 1 = TB6612FNG
.param Vdh={if(driver<0.5,1.1,0)}      ; caida fija lado alto
.param Vdl={if(driver<0.5,0.9,0)}      ; caida fija lado bajo
.param Rd={if(driver<0.5,0.5,0.25)}    ; resistencia por lado
.param Icc_drv={if(driver<0.5,60m,10m)} ; consumo logico del driver (5 V)
.param dutyL=0.85 dutyR=0.85 fpwm=20k tr=20n
.param tpush=60m Tl=0.12        ; instante y torque de empuje (N*m)
.param eta=0.88                 ; eficiencia del buck
.param I_esp=0.1 I_burst=0.0    ; ESP32: base y rafaga WiFi (A)

* ---------------- BATERIA + PROTECCION + CABLEADO --------------------
Vb     bat   0     {Vbat}
Rint   bat   b1    80m          ; resistencia interna LiPo 2S
Rrp    b1    b2    50m          ; fusible + MOSFET P (anti-polaridad)
Lcab   b2    vcc2  150n         ; cableado
Cbulk  vcc2  c1    470u         ; bulk en VCC2
Resr   c1    0     50m
Cdec   vcc2  0     100n
Cinbk  vcc2  0     22u          ; entrada del buck
Bib    ibat  0     V=-I(Vb)     ; corriente de bateria (nodo ibat, 1V = 1A)

* ---------------- BUCK 5 V (modelo de potencia) ----------------------
V5     v5    0     5
Bbk    vcc2  0     I=-V(v5)*I(V5)/(eta*max(V(vcc2),1))

* ---------------- RIEL 3.3 V (LDO de la devkit) ----------------------
V33    v33   0     3.3
B33    v5    0     I=-I(V33)    ; la corriente de 3.3 V sale del riel de 5 V

* ---------------- CARGAS EN EL RIEL DE 5 V ---------------------------
Iesp   v5    0     PULSE({I_esp} {I_esp+I_burst} 1m 10n 10n 0.4m 4.6m)
Ihc    v5    0     15m          ; HC-SR04
Ish    v5    0     30m          ; Sharp
Idrv   v5    0     {Icc_drv}    ; VCC1 del driver
Ileds  v33   0     80m          ; 4 LEDs IR de piso (via 3.3 V)

* ---------------- SENALES DEL ESP32 (EN / IN) ------------------------
VenL_s enL_s 0 PULSE(0 3.3 0 {tr} {tr} {dutyL/fpwm-2*tr} {1/fpwm})
RgL    enL_s enL 40
RpdL   enL   0   10k
CenL   enL   0   10p
VenR_s enR_s 0 PULSE(0 3.3 0 {tr} {tr} {dutyR/fpwm-2*tr} {1/fpwm})
RgR    enR_s enR 40
RpdR   enR   0   10k
CenR   enR   0   10p
VinL1  inL1  0   3.3
VinL2  inL2  0   0
VinR1  inR1  0   3.3
VinR2  inR2  0   0

* ---------------- PUENTES H Y MOTORES --------------------------------
VsL    vcc2  vsL 0              ; sensor de corriente de alimentacion (izq)
VsR    vcc2  vsR 0              ; (der)
XL     vsL enL inL1 inL2 oL1 oL2 HBR Vdh={Vdh} Vdl={Vdl} Rd={Rd}
XR     vsR enR inR1 inR2 oR1 oR2 HBR Vdh={Vdh} Vdl={Vdl} Rd={Rd}
VmL    oL1 mL1 0                ; sensor de corriente de motor (izq)
VmR    oR1 mR1 0                ; (der)
XML    mL1 oL2 N20 Tl={Tl}
XMR    mR1 oR2 N20 Tl={Tl}
CmL    mL1 oL2 100n             ; antirruido en terminales del motor
CmR    mR1 oR2 100n

* ---------------- HC-SR04: divisor de ECHO ---------------------------
Vecho  echo_i 0    PULSE(0 5 2m 20n 20n 1m 20m)
Rso    echo_i echo5 100
R1     echo5  echo3 1.8k
R2     echo3  0     3.3k
Cpin   echo3  0     25p

* ---------------- SHARP -> ADC (rampa 0 a 5 V en 100 ms) -------------
Vsharp sh     0     PWL(0 0 100m 5)
R3     sh     adc   6.8k
R4     adc    0     10k
Cadc   adc    0     100n

* ---------------- 4 SENSORES IR DE PISO ------------------------------
XF1    v33 f1 cf1 FLOOR
XF2    v33 f2 cf2 FLOOR
XF3    v33 f3 cf3 FLOOR
XF4    v33 f4 cf4 FLOOR
Vcf1   cf1 0 PULSE(0 1 15m 10u 10u 10m 100m)
Vcf2   cf2 0 PULSE(0 1 30m 10u 10u 10m 100m)
Vcf3   cf3 0 PULSE(0 1 45m 10u 10u 10m 100m)
Vcf4   cf4 0 PULSE(0 1 70m 10u 10u 10m 100m)

* ---------------- SUBCIRCUITOS ---------------------------------------
* Puente H completo con logica EN/IN (EN=0 -> salidas en alta impedancia)
.subckt HBR vcc en in1 in2 out1 out2 PARAMS: Vdh=1.1 Vdl=0.9 Rd=0.5
B1   c1h 0 V=if(V(en)>1.4,1,0)*if(V(in1)>1.4,1,0)
B2   c1l 0 V=if(V(en)>1.4,1,0)*if(V(in1)>1.4,0,1)
B3   c2h 0 V=if(V(en)>1.4,1,0)*if(V(in2)>1.4,1,0)
B4   c2l 0 V=if(V(en)>1.4,1,0)*if(V(in2)>1.4,0,1)
Sh1  vcc  ah1 c1h 0 SWI
Rh1  ah1  bh1 {Rd}
Vh1  bh1  out1 {Vdh}
Sl1  out1 al1 c1l 0 SWI
Rl1  al1  bl1 {Rd}
Vl1  bl1  0 {Vdl}
Sh2  vcc  ah2 c2h 0 SWI
Rh2  ah2  bh2 {Rd}
Vh2  bh2  out2 {Vdh}
Sl2  out2 al2 c2l 0 SWI
Rl2  al2  bl2 {Rd}
Vl2  bl2  0 {Vdl}
Dh1  out1 vcc DCL
Dl1  0 out1 DCL
Dh2  out2 vcc DCL
Dl2  0 out2 DCL
.ends HBR

* Motor N20: electrico (R, L, fcem) + mecanico (J, friccion, carga)
* Nodo w = velocidad angular (1 V = 1 rad/s) ; corriente = torque (N*m)
.subckt N20 a b PARAMS: Rm=6 Lm=2m Ke=0.176 J=3.9e-5 Bf=1e-4 Tl=0
Rw   a  m1 {Rm}
Lw   m1 m2 {Lm}
Ebk  m2 b  w 0 {Ke}
Bt   0  w  I=Ke*I(Lw)
Cj   w  0  {J}
Rf   w  0  {1/Bf}
Bl   w  0  I=Tl*u(time-tpush)
.ends N20

* Sensor de piso: colector abierto + pull-up + capacidad del pin
.subckt FLOOR vp out ctl
Rpu  vp  out 10k
Sf   out 0 ctl 0 SWOC
Cs   out 0 40p
.ends FLOOR

* ---------------- MODELOS --------------------------------------------
.model SWI  SW(Ron=1m Roff=1Meg Vt=0.5 Vh=0.1)
.model SWOC SW(Ron=100 Roff=10Meg Vt=0.5 Vh=0.05)
.model DCL  D(Is=1n Rs=0.5 Cjo=30p)

* ---------------- ANALISIS -------------------------------------------
.step param driver list 0 1          ; compara L293D (0) vs TB6612 (1)
.tran 0 100m 0 2u
.options plotwinsize=0

* ---------------- MEDICIONES (ver con Ctrl+L) ------------------------
* Marcha libre: 40 ms a 55 ms ; empuje: 85 ms a 100 ms
.meas TRAN Vmot_free  AVG V(mL1,oL2)   FROM 40m TO 55m
.meas TRAN IL_free    AVG I(VmL)       FROM 40m TO 55m
.meas TRAN IL_push    AVG I(VmL)       FROM 85m TO 100m
.meas TRAN IL_pk      MAX I(VmL)
.meas TRAN Vsag       MIN V(vcc2)
.meas TRAN Ibat_pk    MAX V(ibat)
.meas TRAN Ibat_free  AVG V(ibat)      FROM 40m TO 55m
.meas TRAN Ibat_push  AVG V(ibat)      FROM 85m TO 100m
.meas TRAN PsL        AVG V(vsL)*I(VsL)       FROM 85m TO 100m
.meas TRAN PmL        AVG V(mL1,oL2)*I(VmL)   FROM 85m TO 100m
.meas PdrvL           PARAM PsL-PmL
.meas TRAN Vecho_max  MAX V(echo3)
.meas TRAN Vadc_max   MAX V(adc)
.meas TRAN Vfloor_hi  MAX V(f1)
.meas TRAN Vfloor_lo  MIN V(f1)        FROM 20m TO 24m
.end
